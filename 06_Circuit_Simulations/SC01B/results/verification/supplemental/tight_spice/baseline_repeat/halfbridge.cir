SC01B original vendor equations - nominal
.include "C:/Program Files/MATLAB/R2026a/toolbox/physmod/elec/supporting_files/IAUC100N04S6L014.cir"
.options reltol=1.0000000000000001e-05 abstol=1.0000000000000001e-09 vntol=9.9999999999999995e-08 method=trap gminsteps=0 srcsteps=1
Vdc vin 0 24
Rfeed vin f1 0.050000000000000003
Lfeed f1 bus 2e-08
Rcap bus bc 0.01
Cbus bc 0 1.0000000000000001e-05
Vh bus hd 0
Xhigh hd hg sw temp temp IAUC100N04S6L014
Vl sw ld 0
Xlow ld lg 0 temp temp IAUC100N04S6L014
Vtemp temp 0 25
Vhcmd gh0 sw PWL(0 12 2.0190000000000001e-06 12 2.0389999999999999e-06 0 2.3199999999999998e-06 0 2.3399999999999996e-06 0 3.7189999999999999e-06 0 3.7389999999999997e-06 0 4.0199999999999996e-06 0 4.0399999999999994e-06 12 5.0000000000000004e-06 12 )
Vlcmd gl0 0 PWL(0 0 2.0190000000000001e-06 0 2.0389999999999999e-06 0 2.3199999999999998e-06 0 2.3399999999999996e-06 12 3.7189999999999999e-06 12 3.7389999999999997e-06 0 4.0199999999999996e-06 0 4.0399999999999994e-06 0 5.0000000000000004e-06 0 )
Rhgate gh0 gh1 25
Vhg gh1 hg 0
Rlgate gl0 gl1 25
Vlg gl1 lg 0
Lload sw lr 0.0025000000000000001
Rload lr 0 8
.end
